# Ansys Electronics Desktop project, version 2018.1
materials:
  vacuum: permittivity=1
  brass: conductivity=15000000

design HFSSDesign1 (HFSS, DrivenModal, model units mm)
variables:
  ref_len = 338mm
  dip_len = 331.93948mm  # optimise 324mm..334mm
  dip_gap = 6mm
  dir1_len = 313mm
  dir2_len = 311mm
  dir3_len = 308mm
  dip_span = 138mm
  dir1_span = 52mm
  dir2_span = 124mm
  dir3_span = 148mm
  elm_diam = 1mm
geometry:
  Reflector [brass] = cylinder(axis=Z, base_centre=(0mm, 0mm, -ref_len/2), radius=elm_diam/2, height=ref_len)
  Dipole [brass] = cylinder(axis=Z, base_centre=(0mm, dip_span, -(dip_len-dip_gap)/2), radius=elm_diam/2, height=dip_len-dip_gap)
  Dipole_Split1 = Dipole.split(plane=XY, keep=Both)
  Dipole_Split1.move(0mm, 0mm, dip_gap/2)
  Dipole.move(0mm, 0mm, -dip_gap/2)
  Director1 [brass] = cylinder(axis=Z, base_centre=(0mm, dip_span+dir1_span, -dir1_len/2), radius=elm_diam/2, height=dir1_len)
  Dipole.unite(Dipole_Split1)
  Director2 [brass] = cylinder(axis=Z, base_centre=(0mm, dip_span+dir1_span+dir2_span, -dir2_len/2), radius=elm_diam/2, height=dir2_len)
  Director3 [brass] = cylinder(axis=Z, base_centre=(0mm, dip_span+dir1_span+dir2_span+dir3_span, -dir3_len/2), radius=elm_diam/2, height=dir3_len)
  Port = rectangle(corner=(-elm_diam/2, dip_span, -dip_gap/2), z_size=dip_gap, x_size=elm_diam)
  Air [vacuum] = cylinder(axis=Y, base_centre=(0mm, -100mm, 0mm), radius=400mm, height=900mm)
boundaries and excitations:
  Rad1: Radiation Objects=Air
  PerfE1: Perfect E Objects=[Dipole, Director1, Director2, Director3, Reflector]
  1: Lumped Port Objects=Port Modes{Mode1{IntLine{middle of Port.edge(z at corner) -> middle of Port.edge(z opposite corner)} CharImp=Zpi}} Impedance=50ohm
setups:
  Setup1: HfssDriven Frequency=435MHz MaxDeltaS=0.02 MaximumPasses=10 MinimumPasses=1 MinimumConvergedPasses=1 PercentRefinement=30 BasisOrder=1 PortAccuracy=2 IterativeResidual=0.001 DDMSolverResidual=0.0001
    sweep Sweep: 430MHz to 440MHz, 20 points; Type=Fast SaveFields
source amplitudes:
  1:1: 1W 0deg
optimetrics:
  OptimizationSetup1: Optimization Optimizer="Quasi Newton" AnalysisStopOptions{StopForNumIteration MaxNumIteration=1000 MinNumIteration=10} CostFuncNormType=L2 Acceptable_Cost=0 Noise=0.0001 UpdateDesignWhenDone
    goal dB(S(1,1)) <= -20 weight 1 on Setup1 : Sweep at Freq 0.43GHz to 0.44GHz
radiation setups:
  Infinite Sphere1: Infinite Sphere Theta=0deg..180deg step 2deg Phi=-180deg..180deg step 2deg
reports:
  S Parameter Plot 1: dB(S(1,1)) vs Freq on Setup1 : Sweep [dip_len=all]
  Gain Plot 1: dB(GainTotal) vs Theta on Setup1 : LastAdaptive, Infinite Sphere1 [Phi=all Freq=0.435GHz dip_len=all]
  Z Parameter Plot 1: re(Z(1,1)), im(Z(1,1)) vs Freq on Setup1 : Sweep [dip_len=all]
